* CLA3 3-bit Carry-Lookahead Adder transistor-level netlist
* corner 0: VDD = 0.9476988382906772 V, T = -15.17203315358145 C
* inputs a2 a1 a0 b2 b1 b0 cin = 0000000
* gate sizing from gate_common: NAND2 Wn/Wp 180/180 nm, AND2 (NAND+INV), OR2 (NOR+INV)
.include "/home/kowshikh/Documents/Phasors/DVD-Project/45nm_MGK.pm"

.options gmin=1e-18 abstol=1e-18 reltol=1e-6 vntol=1e-9

.temp -15.17203315358145

Vdd vdd 0 DC 0.9476988382906772
Va0 a0 0 DC 0
Va1 a1 0 DC 0
Va2 a2 0 DC 0
Vb0 b0 0 DC 0
Vb1 b1 0 DC 0
Vb2 b2 0 DC 0
Vcin cin 0 DC 0

* and_g0: AND2(a0, b0) -> g0
Mand_g0_mp1 and_g0_n a0 vdd vdd pmos W=1.8e-07 L=4.5e-08
Mand_g0_mp2 and_g0_n b0 vdd vdd pmos W=1.8e-07 L=4.5e-08
Mand_g0_mn1 and_g0_n a0 and_g0_x 0 nmos W=1.8e-07 L=4.5e-08
Mand_g0_mn2 and_g0_x b0 0 0 nmos W=1.8e-07 L=4.5e-08
Mand_g0_mp3 g0 and_g0_n vdd vdd pmos W=1.8e-07 L=4.5e-08
Mand_g0_mn3 g0 and_g0_n 0 0 nmos W=9e-08 L=4.5e-08

* and_g1: AND2(a1, b1) -> g1
Mand_g1_mp1 and_g1_n a1 vdd vdd pmos W=1.8e-07 L=4.5e-08
Mand_g1_mp2 and_g1_n b1 vdd vdd pmos W=1.8e-07 L=4.5e-08
Mand_g1_mn1 and_g1_n a1 and_g1_x 0 nmos W=1.8e-07 L=4.5e-08
Mand_g1_mn2 and_g1_x b1 0 0 nmos W=1.8e-07 L=4.5e-08
Mand_g1_mp3 g1 and_g1_n vdd vdd pmos W=1.8e-07 L=4.5e-08
Mand_g1_mn3 g1 and_g1_n 0 0 nmos W=9e-08 L=4.5e-08

* and_g2: AND2(a2, b2) -> g2
Mand_g2_mp1 and_g2_n a2 vdd vdd pmos W=1.8e-07 L=4.5e-08
Mand_g2_mp2 and_g2_n b2 vdd vdd pmos W=1.8e-07 L=4.5e-08
Mand_g2_mn1 and_g2_n a2 and_g2_x 0 nmos W=1.8e-07 L=4.5e-08
Mand_g2_mn2 and_g2_x b2 0 0 nmos W=1.8e-07 L=4.5e-08
Mand_g2_mp3 g2 and_g2_n vdd vdd pmos W=1.8e-07 L=4.5e-08
Mand_g2_mn3 g2 and_g2_n 0 0 nmos W=9e-08 L=4.5e-08

* xp0_n1: NAND2(a0, b0) -> n1p0
Mxp0_n1_mp1 n1p0 a0 vdd vdd pmos W=1.8e-07 L=4.5e-08
Mxp0_n1_mp2 n1p0 b0 vdd vdd pmos W=1.8e-07 L=4.5e-08
Mxp0_n1_mn1 n1p0 a0 xp0_n1_x 0 nmos W=1.8e-07 L=4.5e-08
Mxp0_n1_mn2 xp0_n1_x b0 0 0 nmos W=1.8e-07 L=4.5e-08

* xp0_n2: NAND2(a0, n1p0) -> n2p0
Mxp0_n2_mp1 n2p0 a0 vdd vdd pmos W=1.8e-07 L=4.5e-08
Mxp0_n2_mp2 n2p0 n1p0 vdd vdd pmos W=1.8e-07 L=4.5e-08
Mxp0_n2_mn1 n2p0 a0 xp0_n2_x 0 nmos W=1.8e-07 L=4.5e-08
Mxp0_n2_mn2 xp0_n2_x n1p0 0 0 nmos W=1.8e-07 L=4.5e-08

* xp0_n3: NAND2(b0, n1p0) -> n3p0
Mxp0_n3_mp1 n3p0 b0 vdd vdd pmos W=1.8e-07 L=4.5e-08
Mxp0_n3_mp2 n3p0 n1p0 vdd vdd pmos W=1.8e-07 L=4.5e-08
Mxp0_n3_mn1 n3p0 b0 xp0_n3_x 0 nmos W=1.8e-07 L=4.5e-08
Mxp0_n3_mn2 xp0_n3_x n1p0 0 0 nmos W=1.8e-07 L=4.5e-08

* xp0_n4: NAND2(n2p0, n3p0) -> p0
Mxp0_n4_mp1 p0 n2p0 vdd vdd pmos W=1.8e-07 L=4.5e-08
Mxp0_n4_mp2 p0 n3p0 vdd vdd pmos W=1.8e-07 L=4.5e-08
Mxp0_n4_mn1 p0 n2p0 xp0_n4_x 0 nmos W=1.8e-07 L=4.5e-08
Mxp0_n4_mn2 xp0_n4_x n3p0 0 0 nmos W=1.8e-07 L=4.5e-08

* xp1_n1: NAND2(a1, b1) -> n1p1
Mxp1_n1_mp1 n1p1 a1 vdd vdd pmos W=1.8e-07 L=4.5e-08
Mxp1_n1_mp2 n1p1 b1 vdd vdd pmos W=1.8e-07 L=4.5e-08
Mxp1_n1_mn1 n1p1 a1 xp1_n1_x 0 nmos W=1.8e-07 L=4.5e-08
Mxp1_n1_mn2 xp1_n1_x b1 0 0 nmos W=1.8e-07 L=4.5e-08

* xp1_n2: NAND2(a1, n1p1) -> n2p1
Mxp1_n2_mp1 n2p1 a1 vdd vdd pmos W=1.8e-07 L=4.5e-08
Mxp1_n2_mp2 n2p1 n1p1 vdd vdd pmos W=1.8e-07 L=4.5e-08
Mxp1_n2_mn1 n2p1 a1 xp1_n2_x 0 nmos W=1.8e-07 L=4.5e-08
Mxp1_n2_mn2 xp1_n2_x n1p1 0 0 nmos W=1.8e-07 L=4.5e-08

* xp1_n3: NAND2(b1, n1p1) -> n3p1
Mxp1_n3_mp1 n3p1 b1 vdd vdd pmos W=1.8e-07 L=4.5e-08
Mxp1_n3_mp2 n3p1 n1p1 vdd vdd pmos W=1.8e-07 L=4.5e-08
Mxp1_n3_mn1 n3p1 b1 xp1_n3_x 0 nmos W=1.8e-07 L=4.5e-08
Mxp1_n3_mn2 xp1_n3_x n1p1 0 0 nmos W=1.8e-07 L=4.5e-08

* xp1_n4: NAND2(n2p1, n3p1) -> p1
Mxp1_n4_mp1 p1 n2p1 vdd vdd pmos W=1.8e-07 L=4.5e-08
Mxp1_n4_mp2 p1 n3p1 vdd vdd pmos W=1.8e-07 L=4.5e-08
Mxp1_n4_mn1 p1 n2p1 xp1_n4_x 0 nmos W=1.8e-07 L=4.5e-08
Mxp1_n4_mn2 xp1_n4_x n3p1 0 0 nmos W=1.8e-07 L=4.5e-08

* xp2_n1: NAND2(a2, b2) -> n1p2
Mxp2_n1_mp1 n1p2 a2 vdd vdd pmos W=1.8e-07 L=4.5e-08
Mxp2_n1_mp2 n1p2 b2 vdd vdd pmos W=1.8e-07 L=4.5e-08
Mxp2_n1_mn1 n1p2 a2 xp2_n1_x 0 nmos W=1.8e-07 L=4.5e-08
Mxp2_n1_mn2 xp2_n1_x b2 0 0 nmos W=1.8e-07 L=4.5e-08

* xp2_n2: NAND2(a2, n1p2) -> n2p2
Mxp2_n2_mp1 n2p2 a2 vdd vdd pmos W=1.8e-07 L=4.5e-08
Mxp2_n2_mp2 n2p2 n1p2 vdd vdd pmos W=1.8e-07 L=4.5e-08
Mxp2_n2_mn1 n2p2 a2 xp2_n2_x 0 nmos W=1.8e-07 L=4.5e-08
Mxp2_n2_mn2 xp2_n2_x n1p2 0 0 nmos W=1.8e-07 L=4.5e-08

* xp2_n3: NAND2(b2, n1p2) -> n3p2
Mxp2_n3_mp1 n3p2 b2 vdd vdd pmos W=1.8e-07 L=4.5e-08
Mxp2_n3_mp2 n3p2 n1p2 vdd vdd pmos W=1.8e-07 L=4.5e-08
Mxp2_n3_mn1 n3p2 b2 xp2_n3_x 0 nmos W=1.8e-07 L=4.5e-08
Mxp2_n3_mn2 xp2_n3_x n1p2 0 0 nmos W=1.8e-07 L=4.5e-08

* xp2_n4: NAND2(n2p2, n3p2) -> p2
Mxp2_n4_mp1 p2 n2p2 vdd vdd pmos W=1.8e-07 L=4.5e-08
Mxp2_n4_mp2 p2 n3p2 vdd vdd pmos W=1.8e-07 L=4.5e-08
Mxp2_n4_mn1 p2 n2p2 xp2_n4_x 0 nmos W=1.8e-07 L=4.5e-08
Mxp2_n4_mn2 xp2_n4_x n3p2 0 0 nmos W=1.8e-07 L=4.5e-08

* and_c1a: AND2(p0, cin) -> c1a
Mand_c1a_mp1 and_c1a_n p0 vdd vdd pmos W=1.8e-07 L=4.5e-08
Mand_c1a_mp2 and_c1a_n cin vdd vdd pmos W=1.8e-07 L=4.5e-08
Mand_c1a_mn1 and_c1a_n p0 and_c1a_x 0 nmos W=1.8e-07 L=4.5e-08
Mand_c1a_mn2 and_c1a_x cin 0 0 nmos W=1.8e-07 L=4.5e-08
Mand_c1a_mp3 c1a and_c1a_n vdd vdd pmos W=1.8e-07 L=4.5e-08
Mand_c1a_mn3 c1a and_c1a_n 0 0 nmos W=9e-08 L=4.5e-08

* or_c1: OR2(g0, c1a) -> c1
Mor_c1_mp1 or_c1_y g0 vdd vdd pmos W=3.6e-07 L=4.5e-08
Mor_c1_mp2 or_c1_n c1a or_c1_y vdd pmos W=3.6e-07 L=4.5e-08
Mor_c1_mn1 or_c1_n g0 0 0 nmos W=9e-08 L=4.5e-08
Mor_c1_mn2 or_c1_n c1a 0 0 nmos W=9e-08 L=4.5e-08
Mor_c1_mp3 c1 or_c1_n vdd vdd pmos W=1.8e-07 L=4.5e-08
Mor_c1_mn3 c1 or_c1_n 0 0 nmos W=9e-08 L=4.5e-08

* and_c2a: AND2(p1, g0) -> c2a
Mand_c2a_mp1 and_c2a_n p1 vdd vdd pmos W=1.8e-07 L=4.5e-08
Mand_c2a_mp2 and_c2a_n g0 vdd vdd pmos W=1.8e-07 L=4.5e-08
Mand_c2a_mn1 and_c2a_n p1 and_c2a_x 0 nmos W=1.8e-07 L=4.5e-08
Mand_c2a_mn2 and_c2a_x g0 0 0 nmos W=1.8e-07 L=4.5e-08
Mand_c2a_mp3 c2a and_c2a_n vdd vdd pmos W=1.8e-07 L=4.5e-08
Mand_c2a_mn3 c2a and_c2a_n 0 0 nmos W=9e-08 L=4.5e-08

* and_p10: AND2(p1, p0) -> p10
Mand_p10_mp1 and_p10_n p1 vdd vdd pmos W=1.8e-07 L=4.5e-08
Mand_p10_mp2 and_p10_n p0 vdd vdd pmos W=1.8e-07 L=4.5e-08
Mand_p10_mn1 and_p10_n p1 and_p10_x 0 nmos W=1.8e-07 L=4.5e-08
Mand_p10_mn2 and_p10_x p0 0 0 nmos W=1.8e-07 L=4.5e-08
Mand_p10_mp3 p10 and_p10_n vdd vdd pmos W=1.8e-07 L=4.5e-08
Mand_p10_mn3 p10 and_p10_n 0 0 nmos W=9e-08 L=4.5e-08

* and_c2b: AND2(p10, cin) -> c2b
Mand_c2b_mp1 and_c2b_n p10 vdd vdd pmos W=1.8e-07 L=4.5e-08
Mand_c2b_mp2 and_c2b_n cin vdd vdd pmos W=1.8e-07 L=4.5e-08
Mand_c2b_mn1 and_c2b_n p10 and_c2b_x 0 nmos W=1.8e-07 L=4.5e-08
Mand_c2b_mn2 and_c2b_x cin 0 0 nmos W=1.8e-07 L=4.5e-08
Mand_c2b_mp3 c2b and_c2b_n vdd vdd pmos W=1.8e-07 L=4.5e-08
Mand_c2b_mn3 c2b and_c2b_n 0 0 nmos W=9e-08 L=4.5e-08

* or_c2a: OR2(g1, c2a) -> c2o
Mor_c2a_mp1 or_c2a_y g1 vdd vdd pmos W=3.6e-07 L=4.5e-08
Mor_c2a_mp2 or_c2a_n c2a or_c2a_y vdd pmos W=3.6e-07 L=4.5e-08
Mor_c2a_mn1 or_c2a_n g1 0 0 nmos W=9e-08 L=4.5e-08
Mor_c2a_mn2 or_c2a_n c2a 0 0 nmos W=9e-08 L=4.5e-08
Mor_c2a_mp3 c2o or_c2a_n vdd vdd pmos W=1.8e-07 L=4.5e-08
Mor_c2a_mn3 c2o or_c2a_n 0 0 nmos W=9e-08 L=4.5e-08

* or_c2: OR2(c2o, c2b) -> c2
Mor_c2_mp1 or_c2_y c2o vdd vdd pmos W=3.6e-07 L=4.5e-08
Mor_c2_mp2 or_c2_n c2b or_c2_y vdd pmos W=3.6e-07 L=4.5e-08
Mor_c2_mn1 or_c2_n c2o 0 0 nmos W=9e-08 L=4.5e-08
Mor_c2_mn2 or_c2_n c2b 0 0 nmos W=9e-08 L=4.5e-08
Mor_c2_mp3 c2 or_c2_n vdd vdd pmos W=1.8e-07 L=4.5e-08
Mor_c2_mn3 c2 or_c2_n 0 0 nmos W=9e-08 L=4.5e-08

* and_c3a: AND2(p2, g1) -> c3a
Mand_c3a_mp1 and_c3a_n p2 vdd vdd pmos W=1.8e-07 L=4.5e-08
Mand_c3a_mp2 and_c3a_n g1 vdd vdd pmos W=1.8e-07 L=4.5e-08
Mand_c3a_mn1 and_c3a_n p2 and_c3a_x 0 nmos W=1.8e-07 L=4.5e-08
Mand_c3a_mn2 and_c3a_x g1 0 0 nmos W=1.8e-07 L=4.5e-08
Mand_c3a_mp3 c3a and_c3a_n vdd vdd pmos W=1.8e-07 L=4.5e-08
Mand_c3a_mn3 c3a and_c3a_n 0 0 nmos W=9e-08 L=4.5e-08

* and_p21: AND2(p2, p1) -> p21
Mand_p21_mp1 and_p21_n p2 vdd vdd pmos W=1.8e-07 L=4.5e-08
Mand_p21_mp2 and_p21_n p1 vdd vdd pmos W=1.8e-07 L=4.5e-08
Mand_p21_mn1 and_p21_n p2 and_p21_x 0 nmos W=1.8e-07 L=4.5e-08
Mand_p21_mn2 and_p21_x p1 0 0 nmos W=1.8e-07 L=4.5e-08
Mand_p21_mp3 p21 and_p21_n vdd vdd pmos W=1.8e-07 L=4.5e-08
Mand_p21_mn3 p21 and_p21_n 0 0 nmos W=9e-08 L=4.5e-08

* and_c3b: AND2(p21, g0) -> c3b
Mand_c3b_mp1 and_c3b_n p21 vdd vdd pmos W=1.8e-07 L=4.5e-08
Mand_c3b_mp2 and_c3b_n g0 vdd vdd pmos W=1.8e-07 L=4.5e-08
Mand_c3b_mn1 and_c3b_n p21 and_c3b_x 0 nmos W=1.8e-07 L=4.5e-08
Mand_c3b_mn2 and_c3b_x g0 0 0 nmos W=1.8e-07 L=4.5e-08
Mand_c3b_mp3 c3b and_c3b_n vdd vdd pmos W=1.8e-07 L=4.5e-08
Mand_c3b_mn3 c3b and_c3b_n 0 0 nmos W=9e-08 L=4.5e-08

* and_p210: AND2(p21, p0) -> p210
Mand_p210_mp1 and_p210_n p21 vdd vdd pmos W=1.8e-07 L=4.5e-08
Mand_p210_mp2 and_p210_n p0 vdd vdd pmos W=1.8e-07 L=4.5e-08
Mand_p210_mn1 and_p210_n p21 and_p210_x 0 nmos W=1.8e-07 L=4.5e-08
Mand_p210_mn2 and_p210_x p0 0 0 nmos W=1.8e-07 L=4.5e-08
Mand_p210_mp3 p210 and_p210_n vdd vdd pmos W=1.8e-07 L=4.5e-08
Mand_p210_mn3 p210 and_p210_n 0 0 nmos W=9e-08 L=4.5e-08

* and_c3c: AND2(p210, cin) -> c3c
Mand_c3c_mp1 and_c3c_n p210 vdd vdd pmos W=1.8e-07 L=4.5e-08
Mand_c3c_mp2 and_c3c_n cin vdd vdd pmos W=1.8e-07 L=4.5e-08
Mand_c3c_mn1 and_c3c_n p210 and_c3c_x 0 nmos W=1.8e-07 L=4.5e-08
Mand_c3c_mn2 and_c3c_x cin 0 0 nmos W=1.8e-07 L=4.5e-08
Mand_c3c_mp3 c3c and_c3c_n vdd vdd pmos W=1.8e-07 L=4.5e-08
Mand_c3c_mn3 c3c and_c3c_n 0 0 nmos W=9e-08 L=4.5e-08

* or_c3a: OR2(g2, c3a) -> c3o1
Mor_c3a_mp1 or_c3a_y g2 vdd vdd pmos W=3.6e-07 L=4.5e-08
Mor_c3a_mp2 or_c3a_n c3a or_c3a_y vdd pmos W=3.6e-07 L=4.5e-08
Mor_c3a_mn1 or_c3a_n g2 0 0 nmos W=9e-08 L=4.5e-08
Mor_c3a_mn2 or_c3a_n c3a 0 0 nmos W=9e-08 L=4.5e-08
Mor_c3a_mp3 c3o1 or_c3a_n vdd vdd pmos W=1.8e-07 L=4.5e-08
Mor_c3a_mn3 c3o1 or_c3a_n 0 0 nmos W=9e-08 L=4.5e-08

* or_c3b: OR2(c3b, c3c) -> c3o2
Mor_c3b_mp1 or_c3b_y c3b vdd vdd pmos W=3.6e-07 L=4.5e-08
Mor_c3b_mp2 or_c3b_n c3c or_c3b_y vdd pmos W=3.6e-07 L=4.5e-08
Mor_c3b_mn1 or_c3b_n c3b 0 0 nmos W=9e-08 L=4.5e-08
Mor_c3b_mn2 or_c3b_n c3c 0 0 nmos W=9e-08 L=4.5e-08
Mor_c3b_mp3 c3o2 or_c3b_n vdd vdd pmos W=1.8e-07 L=4.5e-08
Mor_c3b_mn3 c3o2 or_c3b_n 0 0 nmos W=9e-08 L=4.5e-08

* or_cout: OR2(c3o1, c3o2) -> cout_net
Mor_cout_mp1 or_cout_y c3o1 vdd vdd pmos W=3.6e-07 L=4.5e-08
Mor_cout_mp2 or_cout_n c3o2 or_cout_y vdd pmos W=3.6e-07 L=4.5e-08
Mor_cout_mn1 or_cout_n c3o1 0 0 nmos W=9e-08 L=4.5e-08
Mor_cout_mn2 or_cout_n c3o2 0 0 nmos W=9e-08 L=4.5e-08
Mor_cout_mp3 cout_net or_cout_n vdd vdd pmos W=1.8e-07 L=4.5e-08
Mor_cout_mn3 cout_net or_cout_n 0 0 nmos W=9e-08 L=4.5e-08

* xs0_n1: NAND2(p0, cin) -> sn1_0
Mxs0_n1_mp1 sn1_0 p0 vdd vdd pmos W=1.8e-07 L=4.5e-08
Mxs0_n1_mp2 sn1_0 cin vdd vdd pmos W=1.8e-07 L=4.5e-08
Mxs0_n1_mn1 sn1_0 p0 xs0_n1_x 0 nmos W=1.8e-07 L=4.5e-08
Mxs0_n1_mn2 xs0_n1_x cin 0 0 nmos W=1.8e-07 L=4.5e-08

* xs0_n2: NAND2(p0, sn1_0) -> sn2_0
Mxs0_n2_mp1 sn2_0 p0 vdd vdd pmos W=1.8e-07 L=4.5e-08
Mxs0_n2_mp2 sn2_0 sn1_0 vdd vdd pmos W=1.8e-07 L=4.5e-08
Mxs0_n2_mn1 sn2_0 p0 xs0_n2_x 0 nmos W=1.8e-07 L=4.5e-08
Mxs0_n2_mn2 xs0_n2_x sn1_0 0 0 nmos W=1.8e-07 L=4.5e-08

* xs0_n3: NAND2(cin, sn1_0) -> sn3_0
Mxs0_n3_mp1 sn3_0 cin vdd vdd pmos W=1.8e-07 L=4.5e-08
Mxs0_n3_mp2 sn3_0 sn1_0 vdd vdd pmos W=1.8e-07 L=4.5e-08
Mxs0_n3_mn1 sn3_0 cin xs0_n3_x 0 nmos W=1.8e-07 L=4.5e-08
Mxs0_n3_mn2 xs0_n3_x sn1_0 0 0 nmos W=1.8e-07 L=4.5e-08

* xs0_n4: NAND2(sn2_0, sn3_0) -> s0
Mxs0_n4_mp1 s0 sn2_0 vdd vdd pmos W=1.8e-07 L=4.5e-08
Mxs0_n4_mp2 s0 sn3_0 vdd vdd pmos W=1.8e-07 L=4.5e-08
Mxs0_n4_mn1 s0 sn2_0 xs0_n4_x 0 nmos W=1.8e-07 L=4.5e-08
Mxs0_n4_mn2 xs0_n4_x sn3_0 0 0 nmos W=1.8e-07 L=4.5e-08

* xs1_n1: NAND2(p1, c1) -> sn1_1
Mxs1_n1_mp1 sn1_1 p1 vdd vdd pmos W=1.8e-07 L=4.5e-08
Mxs1_n1_mp2 sn1_1 c1 vdd vdd pmos W=1.8e-07 L=4.5e-08
Mxs1_n1_mn1 sn1_1 p1 xs1_n1_x 0 nmos W=1.8e-07 L=4.5e-08
Mxs1_n1_mn2 xs1_n1_x c1 0 0 nmos W=1.8e-07 L=4.5e-08

* xs1_n2: NAND2(p1, sn1_1) -> sn2_1
Mxs1_n2_mp1 sn2_1 p1 vdd vdd pmos W=1.8e-07 L=4.5e-08
Mxs1_n2_mp2 sn2_1 sn1_1 vdd vdd pmos W=1.8e-07 L=4.5e-08
Mxs1_n2_mn1 sn2_1 p1 xs1_n2_x 0 nmos W=1.8e-07 L=4.5e-08
Mxs1_n2_mn2 xs1_n2_x sn1_1 0 0 nmos W=1.8e-07 L=4.5e-08

* xs1_n3: NAND2(c1, sn1_1) -> sn3_1
Mxs1_n3_mp1 sn3_1 c1 vdd vdd pmos W=1.8e-07 L=4.5e-08
Mxs1_n3_mp2 sn3_1 sn1_1 vdd vdd pmos W=1.8e-07 L=4.5e-08
Mxs1_n3_mn1 sn3_1 c1 xs1_n3_x 0 nmos W=1.8e-07 L=4.5e-08
Mxs1_n3_mn2 xs1_n3_x sn1_1 0 0 nmos W=1.8e-07 L=4.5e-08

* xs1_n4: NAND2(sn2_1, sn3_1) -> s1
Mxs1_n4_mp1 s1 sn2_1 vdd vdd pmos W=1.8e-07 L=4.5e-08
Mxs1_n4_mp2 s1 sn3_1 vdd vdd pmos W=1.8e-07 L=4.5e-08
Mxs1_n4_mn1 s1 sn2_1 xs1_n4_x 0 nmos W=1.8e-07 L=4.5e-08
Mxs1_n4_mn2 xs1_n4_x sn3_1 0 0 nmos W=1.8e-07 L=4.5e-08

* xs2_n1: NAND2(p2, c2) -> sn1_2
Mxs2_n1_mp1 sn1_2 p2 vdd vdd pmos W=1.8e-07 L=4.5e-08
Mxs2_n1_mp2 sn1_2 c2 vdd vdd pmos W=1.8e-07 L=4.5e-08
Mxs2_n1_mn1 sn1_2 p2 xs2_n1_x 0 nmos W=1.8e-07 L=4.5e-08
Mxs2_n1_mn2 xs2_n1_x c2 0 0 nmos W=1.8e-07 L=4.5e-08

* xs2_n2: NAND2(p2, sn1_2) -> sn2_2
Mxs2_n2_mp1 sn2_2 p2 vdd vdd pmos W=1.8e-07 L=4.5e-08
Mxs2_n2_mp2 sn2_2 sn1_2 vdd vdd pmos W=1.8e-07 L=4.5e-08
Mxs2_n2_mn1 sn2_2 p2 xs2_n2_x 0 nmos W=1.8e-07 L=4.5e-08
Mxs2_n2_mn2 xs2_n2_x sn1_2 0 0 nmos W=1.8e-07 L=4.5e-08

* xs2_n3: NAND2(c2, sn1_2) -> sn3_2
Mxs2_n3_mp1 sn3_2 c2 vdd vdd pmos W=1.8e-07 L=4.5e-08
Mxs2_n3_mp2 sn3_2 sn1_2 vdd vdd pmos W=1.8e-07 L=4.5e-08
Mxs2_n3_mn1 sn3_2 c2 xs2_n3_x 0 nmos W=1.8e-07 L=4.5e-08
Mxs2_n3_mn2 xs2_n3_x sn1_2 0 0 nmos W=1.8e-07 L=4.5e-08

* xs2_n4: NAND2(sn2_2, sn3_2) -> s2
Mxs2_n4_mp1 s2 sn2_2 vdd vdd pmos W=1.8e-07 L=4.5e-08
Mxs2_n4_mp2 s2 sn3_2 vdd vdd pmos W=1.8e-07 L=4.5e-08
Mxs2_n4_mn1 s2 sn2_2 xs2_n4_x 0 nmos W=1.8e-07 L=4.5e-08
Mxs2_n4_mn2 xs2_n4_x sn3_2 0 0 nmos W=1.8e-07 L=4.5e-08

.control
set numdgt=15

altermod nmos vth0 = 0.3516567680650164
altermod nmos toxe = 9.348294576189222e-10
altermod nmos ndep = 6.771478713660292e+18
altermod nmos u0 = 0.02776167117819865
altermod nmos xj = 1.425192901868327e-08
altermod pmos vth0 = -0.2347711950807914
altermod pmos toxe = 9.909264394203287e-10
altermod pmos ndep = 2.69912950261189e+18
altermod pmos u0 = 0.00406094700508827
altermod pmos xj = 1.358003403004789e-08

op
.endc
.end
